* 5V CMOS differential opamp core with PMOS current mirror load
VDD VDD 0 DC 5
Vinp_src Vinp 0 DC 2.5 AC 1
Vinn_src Vinn 0 DC 2.5 AC 0
Vbias_src Vbias 0 DC 1.2

M1 Voutp Vinp tail tail NMOS W=50u L=1u
M2 Vout Vinn tail tail NMOS W=50u L=1u
M3 Voutp Voutp VDD VDD PMOS W=100u L=1u
M4 Vout Voutp VDD VDD PMOS W=100u L=1u
M5 tail Vbias 0 0 NMOS W=50u L=1u

Routp_leak Voutp 0 1G
Rout_leak Vout 0 1G

.model NMOS NMOS (LEVEL=1 VTO=0.7 KP=100u LAMBDA=0.02)
.model PMOS PMOS (LEVEL=1 VTO=-0.7 KP=50u LAMBDA=0.02)

.op
.ac dec 20 1 1Meg
.end
