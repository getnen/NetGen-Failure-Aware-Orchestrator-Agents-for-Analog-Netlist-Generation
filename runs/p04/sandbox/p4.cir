* NMOS common-gate amplifier
VDD VDD 0 DC 5
VBIAS Vbias 0 DC 1.8
VIN Vin 0 DC 0.8 AC 1
Rload VDD Vout 47k
M1 Vout Vbias Vin Vin NMOSCG W=50u L=1u
.model NMOSCG NMOS (LEVEL=1 VTO=0.7 KP=100u LAMBDA=0.02)
.op
.ac dec 20 1 1e9
.end
