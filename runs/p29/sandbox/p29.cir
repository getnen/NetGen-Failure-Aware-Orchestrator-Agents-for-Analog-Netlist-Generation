* p29.cir single-supply MOS Wien-bridge VCO
VVSS VSS 0 0
VDD1 VDD VSS DC 12
VCTRL1 Vctrl VSS DC 3.8
VVIN Vin VREF SIN(0 2m 1000)

RREF1 VDD VREF 10k
RREF2 VREF VSS 10k
CVREF VREF VSS 10u IC=6

RINJ Vin Vinp 10Meg

RFB Vout Vinn 220k
RGB Vinn VREF 100k

C1 Vout NBR 2.2n IC=0
RB1 NBR NBRX 1.5k
MVR1 NBRX Vctrl Vinp VDD PMOSVCR W=8u L=20u

RB2 Vinp NSHX 1.5k
MVR2 NSHX Vctrl VREF VDD PMOSVCR W=8u L=20u
C2 Vinp VREF 2.2n IC=1m

RBIAS VDD VBN 180k
MBIAS VBN VBN VSS VSS NMOSCORE W=20u L=4u

MTAIL NSRC VBN VSS VSS NMOSCORE W=60u L=4u
M1 NL Vinn NSRC VSS NMOSCORE W=120u L=2u
M2 N1 Vinp NSRC VSS NMOSCORE W=120u L=2u
M3 NL NL VDD VDD PMOSCORE W=240u L=2u
M4 N1 NL VDD VDD PMOSCORE W=240u L=2u

M6 Vout N1 VDD VDD PMOSCORE W=80u L=2u
M7 Vout VBN VSS VSS NMOSCORE W=90u L=4u
CCOMP N1 Vout 22p

.model NMOSCORE NMOS (LEVEL=1 VTO=1.2 KP=220u LAMBDA=0.02 GAMMA=0 PHI=0.7)
.model PMOSCORE PMOS (LEVEL=1 VTO=-1.0 KP=90u LAMBDA=0.02 GAMMA=0 PHI=0.7)
.model PMOSVCR PMOS (LEVEL=1 VTO=-1.0 KP=70u LAMBDA=0.01 GAMMA=0 PHI=0.7)

.ic V(Vout)=5.8 V(Vinp)=6.01 V(Vinn)=6.0 V(NBR)=6.0

.op
.tran 2u 20m
.meas tran tper TRIG v(Vout) VAL=6.0 RISE=25 TARG v(Vout) VAL=6.0 RISE=26
.meas tran freq PARAM='1/tper'
.end
