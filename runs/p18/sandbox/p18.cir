* Single-stage NMOS differential amplifier with PMOS current mirror active load
VDD VDD 0 DC 5
Vinp Vinp 0 DC 2.5
Vinn Vinn 0 DC 2.5
Vbias Vbias_tail 0 DC 1.2
M1 Nmirror Vinp Ntail Ntail NMOS W=50u L=1u
M2 Vout Vinn Ntail Ntail NMOS W=50u L=1u
M3 Nmirror Nmirror VDD VDD PMOS W=100u L=1u
M4 Vout Nmirror VDD VDD PMOS W=100u L=1u
M5 Ntail Vbias_tail 0 0 NMOS W=50u L=1u
.model NMOS NMOS (VTO=0.7 KP=100u)
.model PMOS PMOS (VTO=-0.7 KP=50u)
.op
.end
