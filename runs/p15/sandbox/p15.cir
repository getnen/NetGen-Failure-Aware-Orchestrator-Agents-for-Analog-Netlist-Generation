* Single-stage NMOS common-source amplifier with diode-connected PMOS load
VDD VDD 0 DC 5
Vin Vin 0 DC 1.5 AC 1
M1 Vout Vin 0 0 NMOS_MODEL W=50u L=1u
M2 Vout Vout VDD VDD PMOS_MODEL W=100u L=1u
.model NMOS_MODEL NMOS (VTO=0.7 KP=100u)
.model PMOS_MODEL PMOS (VTO=-0.7 KP=50u)
.op
.ac dec 20 1 1e9
.end
