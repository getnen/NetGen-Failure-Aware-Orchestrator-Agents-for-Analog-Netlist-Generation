* Passive RC band-pass filter
V1 Vin 0 AC 1
C1 Vin N1 10n
R1 N1 0 10k
R2 N1 Vout 10k
C2 Vout 0 1n
.ac dec 20 1 1e9
.print ac vm(Vout) vp(Vout)

.control
set filetype=ascii
set wr_singlescale
ac dec 20 1 1e9
wrdata <REDACTED> frequency vm(Vout)
quit
.endc
.end
