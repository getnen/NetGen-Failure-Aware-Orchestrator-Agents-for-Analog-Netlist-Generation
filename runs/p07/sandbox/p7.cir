* 5 V CMOS inverter
VDD VDD 0 DC 5
Vin Vin 0 DC 0
Mn1 Vout Vin 0 0 NMOS W=10u L=1u
Mp1 Vout Vin VDD VDD PMOS W=10u L=1u
.model NMOS NMOS (LEVEL=1 VTO=0.7 KP=100u)
.model PMOS PMOS (LEVEL=1 VTO=-0.7 KP=50u)
.dc Vin 0 5 0.1
.end
