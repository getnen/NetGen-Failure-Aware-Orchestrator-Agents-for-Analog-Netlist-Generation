* Two-stage CMOS amplifier with Miller compensation
VDD VDD 0 DC 5
Vin Vin 0 DC 1.2 AC 1
VBP Vbp 0 DC 3.8

M1 N1 Vin 0 0 NMOS W=50u L=1u
M2 N1 Vbp VDD VDD PMOS W=100u L=1u
M3 Vout N1 0 0 NMOS W=50u L=1u
M4 Vout Vbp VDD VDD PMOS W=100u L=1u

Cc Vout N1 2p
RL Vout 0 50k

.model NMOS NMOS (LEVEL=1 VTO=0.7 KP=100u LAMBDA=0.02)
.model PMOS PMOS (LEVEL=1 VTO=-0.7 KP=50u LAMBDA=0.02)

.op
.ac dec 20 1 1e9
.end
