* RC high-pass filter
V1 Vin 0 AC 1
C1 Vin Vout 1u
R1 Vout 0 1k
.ac dec 20 1 1e9

.control
set filetype=ascii
set wr_singlescale
ac dec 20 1 1e9
wrdata <REDACTED> frequency vm(Vout)
quit
.endc
.end
